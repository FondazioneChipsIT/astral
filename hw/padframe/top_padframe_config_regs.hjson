# Copyright 2026 Fondazione Chips-IT.
# Licensed under the Apache License, Version 2.0, see LICENSE for details.
# SPDX-License-Identifier: Apache-2.0
#
# Author: Riccardo Fiorani Gallotta <riccardo.fiorani3@unibo.it>

{
    name: "top_padframe_config"
    clock_primary: "clk_i"
    reset_primary: "rst_ni"
    bus_interfaces: [
        { protocol: "reg_iface", direction: "device" }
    ]
    regwidth: 32,
    registers: [
        { skipto: "0x0" }
        {
            name: INFO
            desc: "Read-only IP Information register"
            swaccess: "ro"
            hwaccess: "hro"
            fields: [
                {
                    bits: "15:0"
                    name: HW_VERSION
                    desc: "Hardware version ID."
                    resval: 2
                },
                {
                    bits:"31:16"
                    name: PAD_COUNT
                    desc: "The number of configurable pads."
                    resval: 22
                }
            ]
        }
        {
            name: PAD_FLL_HOST
            desc: "Configuration register for PAD_FLL_HOST"
            swaccess: "rw"
            hwaccess: "hro"
            fields: [
                {
                    bits: "1:1"
                    name: SLEW_EN
                    desc: "Slew enable"
                    resval: 0
                },
                {
                    bits: "3:2"
                    name: DRV_STR
                    desc: "Drive strength"
                    resval: 0
                }
            ]
        }
        {
            name: PAD_FLL_SECD
            desc: "Configuration register for PAD_FLL_SECD"
            swaccess: "rw"
            hwaccess: "hro"
            fields: [
                {
                    bits: "1:1"
                    name: SLEW_EN
                    desc: "Slew enable"
                    resval: 0
                },
                {
                    bits: "3:2"
                    name: DRV_STR
                    desc: "Drive strength"
                    resval: 0
                }
            ]
        }
        {
            name: PAD_JTAG_TDO
            desc: "Configuration register for PAD_JTAG_TDO"
            swaccess: "rw"
            hwaccess: "hro"
            fields: [
                {
                    bits: "1:1"
                    name: SLEW_EN
                    desc: "Slew enable"
                    resval: 0
                },
                {
                    bits: "3:2"
                    name: DRV_STR
                    desc: "Drive strength"
                    resval: 0
                }
            ]
        }
        {
            name: PAD_UART_TX
            desc: "Configuration register for PAD_UART_TX"
            swaccess: "rw"
            hwaccess: "hro"
            fields: [
                {
                    bits: "1:1"
                    name: SLEW_EN
                    desc: "Slew enable"
                    resval: 0
                },
                {
                    bits: "3:2"
                    name: DRV_STR
                    desc: "Drive strength"
                    resval: 0
                }
            ]
        }
        {
            name: PAD_GPIO_0
            desc: "Configuration register for PAD_GPIO_0"
            swaccess: "rw"
            hwaccess: "hro"
            fields: [
                {
                    bits: "0:0"
                    name: PAD_EN
                    desc: "Pad enable"
                    resval: 0
                },
                {
                    bits: "1:1"
                    name: SLEW_EN
                    desc: "Slew enable"
                    resval: 0
                },
                {
                    bits: "3:2"
                    name: DRV_STR
                    desc: "Drive strength"
                    resval: 0
                }
                {
                    bits: "4:4"
                    name: PD_EN
                    desc: "Pull down enable"
                    resval: 0
                },
                {
                    bits: "5:5"
                    name: PU_EN
                    desc: "Pull up enable"
                    resval: 0
                },
                {
                    bits: "6:6"
                    name: SMT_EN
                    desc: "Schmitt trigger enable"
                    resval: 0
                },
            ]
        }
        {
            name: PAD_GPIO_1
            desc: "Configuration register for PAD_GPIO_1"
            swaccess: "rw"
            hwaccess: "hro"
            fields: [
                {
                    bits: "0:0"
                    name: PAD_EN
                    desc: "Pad enable"
                    resval: 0
                },
                {
                    bits: "1:1"
                    name: SLEW_EN
                    desc: "Slew enable"
                    resval: 0
                },
                {
                    bits: "3:2"
                    name: DRV_STR
                    desc: "Drive strength"
                    resval: 0
                }
                {
                    bits: "4:4"
                    name: PD_EN
                    desc: "Pull down enable"
                    resval: 0
                },
                {
                    bits: "5:5"
                    name: PU_EN
                    desc: "Pull up enable"
                    resval: 0
                },
                {
                    bits: "6:6"
                    name: SMT_EN
                    desc: "Schmitt trigger enable"
                    resval: 0
                },
            ]
        }
        {
            name: PAD_GPIO_2
            desc: "Configuration register for PAD_GPIO_2"
            swaccess: "rw"
            hwaccess: "hro"
            fields: [
                {
                    bits: "0:0"
                    name: PAD_EN
                    desc: "Pad enable"
                    resval: 0
                },
                {
                    bits: "1:1"
                    name: SLEW_EN
                    desc: "Slew enable"
                    resval: 0
                },
                {
                    bits: "3:2"
                    name: DRV_STR
                    desc: "Drive strength"
                    resval: 0
                }
                {
                    bits: "4:4"
                    name: PD_EN
                    desc: "Pull down enable"
                    resval: 0
                },
                {
                    bits: "5:5"
                    name: PU_EN
                    desc: "Pull up enable"
                    resval: 0
                },
                {
                    bits: "6:6"
                    name: SMT_EN
                    desc: "Schmitt trigger enable"
                    resval: 0
                },
            ]
        }
        {
            name: PAD_GPIO_3
            desc: "Configuration register for PAD_GPIO_3"
            swaccess: "rw"
            hwaccess: "hro"
            fields: [
                {
                    bits: "0:0"
                    name: PAD_EN
                    desc: "Pad enable"
                    resval: 0
                },
                {
                    bits: "1:1"
                    name: SLEW_EN
                    desc: "Slew enable"
                    resval: 0
                },
                {
                    bits: "3:2"
                    name: DRV_STR
                    desc: "Drive strength"
                    resval: 0
                }
                {
                    bits: "4:4"
                    name: PD_EN
                    desc: "Pull down enable"
                    resval: 0
                },
                {
                    bits: "5:5"
                    name: PU_EN
                    desc: "Pull up enable"
                    resval: 0
                },
                {
                    bits: "6:6"
                    name: SMT_EN
                    desc: "Schmitt trigger enable"
                    resval: 0
                },
            ]
        }
        {
            name: PAD_JTAG_OT_TDO
            desc: "Configuration register for PAD_JTAG_OT_TDO"
            swaccess: "rw"
            hwaccess: "hro"
            fields: [
                {
                    bits: "1:1"
                    name: SLEW_EN
                    desc: "Slew enable"
                    resval: 0
                },
                {
                    bits: "3:2"
                    name: DRV_STR
                    desc: "Drive strength"
                    resval: 0
                }
            ]
        }
        {
            name: PAD_OT_UART_TX
            desc: "Configuration register for PAD_OT_UART_TX"
            swaccess: "rw"
            hwaccess: "hro"
            fields: [
                {
                    bits: "1:1"
                    name: SLEW_EN
                    desc: "Slew enable"
                    resval: 0
                },
                {
                    bits: "3:2"
                    name: DRV_STR
                    desc: "Drive strength"
                    resval: 0
                }
            ]
        }
        {
            name: PAD_SPIH_SCK
            desc: "Configuration register for PAD_SPIH_SCK"
            swaccess: "rw"
            hwaccess: "hro"
            fields: [
                {
                    bits: "0:0"
                    name: PAD_EN
                    desc: "Pad enable"
                    resval: 1
                },
                {
                    bits: "1:1"
                    name: SLEW_EN
                    desc: "Slew enable"
                    resval: 0
                },
                {
                    bits: "3:2"
                    name: DRV_STR
                    desc: "Drive strength"
                    resval: 0
                }
            ]
        }
        {
            name: PAD_SPIH_CSB
            desc: "Configuration register for PAD_SPIH_CSB"
            swaccess: "rw"
            hwaccess: "hro"
            fields: [
                {
                    bits: "0:0"
                    name: PAD_EN
                    desc: "Pad enable"
                    resval: 1
                },
                {
                    bits: "1:1"
                    name: SLEW_EN
                    desc: "Slew enable"
                    resval: 0
                },
                {
                    bits: "3:2"
                    name: DRV_STR
                    desc: "Drive strength"
                    resval: 0
                }
            ]
        }
        {
            name: PAD_SPIH_SD_0
            desc: "Configuration register for PAD_SPIH_SD_0"
            swaccess: "rw"
            hwaccess: "hro"
            fields: [
                {
                    bits: "0:0"
                    name: PAD_EN
                    desc: "Pad enable"
                    resval: 1
                },
                {
                    bits: "1:1"
                    name: SLEW_EN
                    desc: "Slew enable"
                    resval: 0
                },
                {
                    bits: "3:2"
                    name: DRV_STR
                    desc: "Drive strength"
                    resval: 0
                }
                {
                    bits: "4:4"
                    name: PD_EN
                    desc: "Pull down enable"
                    resval: 0
                },
                {
                    bits: "5:5"
                    name: PU_EN
                    desc: "Pull up enable"
                    resval: 1
                },
                {
                    bits: "6:6"
                    name: SMT_EN
                    desc: "Schmitt trigger enable"
                    resval: 1
                },
            ]
        }
        {
            name: PAD_SPIH_SD_1
            desc: "Configuration register for PAD_SPIH_SD_1"
            swaccess: "rw"
            hwaccess: "hro"
            fields: [
                {
                    bits: "0:0"
                    name: PAD_EN
                    desc: "Pad enable"
                    resval: 1
                },
                {
                    bits: "1:1"
                    name: SLEW_EN
                    desc: "Slew enable"
                    resval: 0
                },
                {
                    bits: "3:2"
                    name: DRV_STR
                    desc: "Drive strength"
                    resval: 0
                }
                {
                    bits: "4:4"
                    name: PD_EN
                    desc: "Pull down enable"
                    resval: 0
                },
                {
                    bits: "5:5"
                    name: PU_EN
                    desc: "Pull up enable"
                    resval: 1
                },
                {
                    bits: "6:6"
                    name: SMT_EN
                    desc: "Schmitt trigger enable"
                    resval: 1
                },
            ]
        }
        {
            name: PAD_SPIH_SD_2
            desc: "Configuration register for PAD_SPIH_SD_2"
            swaccess: "rw"
            hwaccess: "hro"
            fields: [
                {
                    bits: "0:0"
                    name: PAD_EN
                    desc: "Pad enable"
                    resval: 1
                },
                {
                    bits: "1:1"
                    name: SLEW_EN
                    desc: "Slew enable"
                    resval: 0
                },
                {
                    bits: "3:2"
                    name: DRV_STR
                    desc: "Drive strength"
                    resval: 0
                }
                {
                    bits: "4:4"
                    name: PD_EN
                    desc: "Pull down enable"
                    resval: 0
                },
                {
                    bits: "5:5"
                    name: PU_EN
                    desc: "Pull up enable"
                    resval: 1
                },
                {
                    bits: "6:6"
                    name: SMT_EN
                    desc: "Schmitt trigger enable"
                    resval: 1
                },
            ]
        }
        {
            name: PAD_SPIH_SD_3
            desc: "Configuration register for PAD_SPIH_SD_3"
            swaccess: "rw"
            hwaccess: "hro"
            fields: [
                {
                    bits: "0:0"
                    name: PAD_EN
                    desc: "Pad enable"
                    resval: 1
                },
                {
                    bits: "1:1"
                    name: SLEW_EN
                    desc: "Slew enable"
                    resval: 0
                },
                {
                    bits: "3:2"
                    name: DRV_STR
                    desc: "Drive strength"
                    resval: 0
                }
                {
                    bits: "4:4"
                    name: PD_EN
                    desc: "Pull down enable"
                    resval: 0
                },
                {
                    bits: "5:5"
                    name: PU_EN
                    desc: "Pull up enable"
                    resval: 1
                },
                {
                    bits: "6:6"
                    name: SMT_EN
                    desc: "Schmitt trigger enable"
                    resval: 1
                },
            ]
        }
        {
            name: PAD_SPIH_OT_SCK
            desc: "Configuration register for PAD_SPIH_OT_SCK"
            swaccess: "rw"
            hwaccess: "hro"
            fields: [
                {
                    bits: "0:0"
                    name: PAD_EN
                    desc: "Pad enable"
                    resval: 1
                },
                {
                    bits: "1:1"
                    name: SLEW_EN
                    desc: "Slew enable"
                    resval: 0
                },
                {
                    bits: "3:2"
                    name: DRV_STR
                    desc: "Drive strength"
                    resval: 0
                }
            ]
        }
        {
            name: PAD_SPIH_OT_CSB
            desc: "Configuration register for PAD_SPIH_OT_CSB"
            swaccess: "rw"
            hwaccess: "hro"
            fields: [
                {
                    bits: "0:0"
                    name: PAD_EN
                    desc: "Pad enable"
                    resval: 1
                },
                {
                    bits: "1:1"
                    name: SLEW_EN
                    desc: "Slew enable"
                    resval: 0
                },
                {
                    bits: "3:2"
                    name: DRV_STR
                    desc: "Drive strength"
                    resval: 0
                }
            ]
        }
        {
            name: PAD_SPIH_OT_SD_0
            desc: "Configuration register for PAD_SPIH_OT_SD_0"
            swaccess: "rw"
            hwaccess: "hro"
            fields: [
                {
                    bits: "0:0"
                    name: PAD_EN
                    desc: "Pad enable"
                    resval: 1
                },
                {
                    bits: "1:1"
                    name: SLEW_EN
                    desc: "Slew enable"
                    resval: 0
                },
                {
                    bits: "3:2"
                    name: DRV_STR
                    desc: "Drive strength"
                    resval: 0
                }
                {
                    bits: "4:4"
                    name: PD_EN
                    desc: "Pull down enable"
                    resval: 0
                },
                {
                    bits: "5:5"
                    name: PU_EN
                    desc: "Pull up enable"
                    resval: 1
                },
                {
                    bits: "6:6"
                    name: SMT_EN
                    desc: "Schmitt trigger enable"
                    resval: 1
                },
            ]
        }
        {
            name: PAD_SPIH_OT_SD_1
            desc: "Configuration register for PAD_SPIH_OT_SD_1"
            swaccess: "rw"
            hwaccess: "hro"
            fields: [
                {
                    bits: "0:0"
                    name: PAD_EN
                    desc: "Pad enable"
                    resval: 1
                },
                {
                    bits: "1:1"
                    name: SLEW_EN
                    desc: "Slew enable"
                    resval: 0
                },
                {
                    bits: "3:2"
                    name: DRV_STR
                    desc: "Drive strength"
                    resval: 0
                }
                {
                    bits: "4:4"
                    name: PD_EN
                    desc: "Pull down enable"
                    resval: 0
                },
                {
                    bits: "5:5"
                    name: PU_EN
                    desc: "Pull up enable"
                    resval: 1
                },
                {
                    bits: "6:6"
                    name: SMT_EN
                    desc: "Schmitt trigger enable"
                    resval: 1
                },
            ]
        }
        {
            name: PAD_SPIH_OT_SD_2
            desc: "Configuration register for PAD_SPIH_OT_SD_2"
            swaccess: "rw"
            hwaccess: "hro"
            fields: [
                {
                    bits: "0:0"
                    name: PAD_EN
                    desc: "Pad enable"
                    resval: 1
                },
                {
                    bits: "1:1"
                    name: SLEW_EN
                    desc: "Slew enable"
                    resval: 0
                },
                {
                    bits: "3:2"
                    name: DRV_STR
                    desc: "Drive strength"
                    resval: 0
                }
                {
                    bits: "4:4"
                    name: PD_EN
                    desc: "Pull down enable"
                    resval: 0
                },
                {
                    bits: "5:5"
                    name: PU_EN
                    desc: "Pull up enable"
                    resval: 1
                },
                {
                    bits: "6:6"
                    name: SMT_EN
                    desc: "Schmitt trigger enable"
                    resval: 1
                },
            ]
        }
        {
            name: PAD_SPIH_OT_SD_3
            desc: "Configuration register for PAD_SPIH_OT_SD_3"
            swaccess: "rw"
            hwaccess: "hro"
            fields: [
                {
                    bits: "0:0"
                    name: PAD_EN
                    desc: "Pad enable"
                    resval: 1
                },
                {
                    bits: "1:1"
                    name: SLEW_EN
                    desc: "Slew enable"
                    resval: 0
                },
                {
                    bits: "3:2"
                    name: DRV_STR
                    desc: "Drive strength"
                    resval: 0
                }
                {
                    bits: "4:4"
                    name: PD_EN
                    desc: "Pull down enable"
                    resval: 0
                },
                {
                    bits: "5:5"
                    name: PU_EN
                    desc: "Pull up enable"
                    resval: 1
                },
                {
                    bits: "6:6"
                    name: SMT_EN
                    desc: "Schmitt trigger enable"
                    resval: 1
                },
            ]
        }
    ]
}
