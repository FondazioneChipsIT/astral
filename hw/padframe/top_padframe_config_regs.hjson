# Copyright 2026 Fondazione Chips-IT.
# Licensed under the Apache License, Version 2.0, see LICENSE for details.
# SPDX-License-Identifier: Apache-2.0
#
# Author: Riccardo Fiorani Gallotta <riccardo.fiorani3@unibo.it>

{
    name: "top_padframe_config"
    clock_primary: "clk_i"
    reset_primary: "rst_ni"
    bus_interfaces: [
        { protocol: "reg_iface", direction: "device" }
    ]
    regwidth: 32,
    registers: [
        { skipto: "0x0" }
        {
            name: INFO
            desc: "Read-only IP Information register"
            swaccess: "ro"
            hwaccess: "hro"
            fields: [
                {
                    bits: "15:0"
                    name: HW_VERSION
                    desc: "Hardware version ID."
                    resval: 2
                },
                {
                    bits:"31:16"
                    name: PADGROUP_COUNT
                    desc: "The number of configurable pad groups."
                    resval: 11
                }
            ]
        }
        {
            name: DRV_STR_CFG
            desc: "Pad groups drive strength configuration register"
            swaccess: "rw"
            hwaccess: "hro"
            fields: [
                {
                    bits: "1:0"
                    name: DRV_STR_PG_1
                    desc: "Drive strength for pad group 1"
                    resval: 0
                },
                {
                    bits: "3:2"
                    name: DRV_STR_PG_2
                    desc: "Drive strength for pad group 2"
                    resval: 0
                },
                {
                    bits: "5:4"
                    name: DRV_STR_PG_3
                    desc: "Drive strength for pad group 3"
                    resval: 0
                },
                {
                    bits: "7:6"
                    name: DRV_STR_PG_4
                    desc: "Drive strength for pad group 4"
                    resval: 0
                },
                {
                    bits: "9:8"
                    name: DRV_STR_PG_5
                    desc: "Drive strength for pad group 5"
                    resval: 0
                },
                {
                    bits: "11:10"
                    name: DRV_STR_PG_6
                    desc: "Drive strength for pad group 6"
                    resval: 0
                },
                {
                    bits: "13:12"
                    name: DRV_STR_PG_7
                    desc: "Drive strength for pad group 7"
                    resval: 0
                },
                {
                    bits: "15:14"
                    name: DRV_STR_PG_8
                    desc: "Drive strength for pad group 8"
                    resval: 0
                },
                {
                    bits: "17:16"
                    name: DRV_STR_PG_9
                    desc: "Drive strength for pad group 9"
                    resval: 0
                },
                {
                    bits: "19:18"
                    name: DRV_STR_PG_10
                    desc: "Drive strength for pad group 10"
                    resval: 0
                },
                {
                    bits: "21:20"
                    name: DRV_STR_PG_11
                    desc: "Drive strength for pad group 11"
                    resval: 0
                }
            ]
        }
        {
            name: SLW_CFG
            desc: "Pad groups slew enable configuration register. 0 for VDDIO=1.8V, 1 for VDDIO=1.6V or 1.2V"
            swaccess: "rw"
            hwaccess: "hro"
            fields: [
                {
                    bits: "0:0"
                    name: SLW_PG_1
                    desc: "Slew enable for pad group 1"
                    resval: 0
                }
                {
                    bits: "1:1"
                    name: SLW_PG_2
                    desc: "Slew enable for pad group 2"
                    resval: 0
                }
                {
                    bits: "2:2"
                    name: SLW_PG_3
                    desc: "Slew enable for pad group 3"
                    resval: 0
                }
                {
                    bits: "3:3"
                    name: SLW_PG_4
                    desc: "Slew enable for pad group 4"
                    resval: 0
                }
                {
                    bits: "4:4"
                    name: SLW_PG_5
                    desc: "Slew enable for pad group 5"
                    resval: 0
                }
                {
                    bits: "5:5"
                    name: SLW_PG_6
                    desc: "Slew enable for pad group 6"
                    resval: 0
                }
                {
                    bits: "6:6"
                    name: SLW_PG_7
                    desc: "Slew enable for pad group 7"
                    resval: 0
                }
                {
                    bits: "7:7"
                    name: SLW_PG_8
                    desc: "Slew enable for pad group 8"
                    resval: 0
                }
                {
                    bits: "8:8"
                    name: SLW_PG_9
                    desc: "Slew enable for pad group 9"
                    resval: 0
                }
                {
                    bits: "9:9"
                    name: SLW_PG_10
                    desc: "Slew enable for pad group 10"
                    resval: 0
                }
                {
                    bits: "10:10"
                    name: SLW_PG_11
                    desc: "Slew enable for pad group 11"
                    resval: 0
                }
            ]
        }
    ]
}
