

{
    # File auto-generated by Padrick unknown
    # 
    # Copyright 2026 Fondazione Chips-IT.
    # Licensed under the Apache License, Version 2.0, see LICENSE for details.
    # SPDX-License-Identifier: Apache-2.0
    name: "astral_padframe_botl_config"
    clock_primary: "clk_i"
    reset_primary: "rst_ni"
    bus_interfaces: [
        { protocol: "reg_iface", direction: "device"}
    ]
    regwidth: 32,
    registers: [
        {skipto: "0x0"},
        {
            name: INFO
            desc: "Read-only IP Information register"
            swaccess: "ro"
            hwaccess: "hro"
            fields: [
              {
                bits: "15:0"
                name: HW_VERSION
                desc: "Hardware version ID."
                resval: 2
              },
              {
                  bits:"31:16"
                  name: PADCOUNT
                  desc: "The number of muxable pads in this IP."
                  resval: "0"
              }
            ]
        }






























































    ]
}
